.title 4-bit Flash ADC
Vdd vdd 0 1.8
Vref vref 0 1.8
Vin vin 0 1.0
Rlad0 0 tap[0] 1000.0
Rlad1 tap[0] tap[1] 1000.0
Rlad2 tap[1] tap[2] 1000.0
Rlad3 tap[2] tap[3] 1000.0
Rlad4 tap[3] tap[4] 1000.0
Rlad5 tap[4] tap[5] 1000.0
Rlad6 tap[5] tap[6] 1000.0
Rlad7 tap[6] tap[7] 1000.0
Rlad8 tap[7] tap[8] 1000.0
Rlad9 tap[8] tap[9] 1000.0
Rlad10 tap[9] tap[10] 1000.0
Rlad11 tap[10] tap[11] 1000.0
Rlad12 tap[11] tap[12] 1000.0
Rlad13 tap[12] tap[13] 1000.0
Rlad14 tap[13] tap[14] 1000.0
Rlad15 tap[14] tap[15] 1000.0
Rlad_top tap[15] vref 1000.0
Ecmp0 comp[0] 0 vin tap[0] 10000.0
Ecmp1 comp[1] 0 vin tap[1] 10000.0
Ecmp2 comp[2] 0 vin tap[2] 10000.0
Ecmp3 comp[3] 0 vin tap[3] 10000.0
Ecmp4 comp[4] 0 vin tap[4] 10000.0
Ecmp5 comp[5] 0 vin tap[5] 10000.0
Ecmp6 comp[6] 0 vin tap[6] 10000.0
Ecmp7 comp[7] 0 vin tap[7] 10000.0
Ecmp8 comp[8] 0 vin tap[8] 10000.0
Ecmp9 comp[9] 0 vin tap[9] 10000.0
Ecmp10 comp[10] 0 vin tap[10] 10000.0
Ecmp11 comp[11] 0 vin tap[11] 10000.0
Ecmp12 comp[12] 0 vin tap[12] 10000.0
Ecmp13 comp[13] 0 vin tap[13] 10000.0
Ecmp14 comp[14] 0 vin tap[14] 10000.0
Rd0 comp[0] dout[0] 10000.0
Rd1 comp[1] dout[1] 10000.0
Rd2 comp[3] dout[2] 10000.0
Rd3 comp[7] dout[3] 10000.0
Rpd0 dout[0] 0 100000.0
Rpd1 dout[1] 0 100000.0
Rpd2 dout[2] 0 100000.0
Rpd3 dout[3] 0 100000.0
.end
