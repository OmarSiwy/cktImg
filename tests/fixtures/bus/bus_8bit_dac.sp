.title 8-bit R-2R DAC
Vdata[0] data[0] 0 0.0
Vdata[1] data[1] 0 3.3
Vdata[2] data[2] 0 0.0
Vdata[3] data[3] 0 3.3
Vdata[4] data[4] 0 0.0
Vdata[5] data[5] 0 3.3
Vdata[6] data[6] 0 0.0
Vdata[7] data[7] 0 3.3
Rterm n0 0 20000.0
R2r0 data[0] n0 20000.0
Rr0 n0 n1 10000.0
R2r1 data[1] n1 20000.0
Rr1 n1 n2 10000.0
R2r2 data[2] n2 20000.0
Rr2 n2 n3 10000.0
R2r3 data[3] n3 20000.0
Rr3 n3 n4 10000.0
R2r4 data[4] n4 20000.0
Rr4 n4 n5 10000.0
R2r5 data[5] n5 20000.0
Rr5 n5 n6 10000.0
R2r6 data[6] n6 20000.0
Rr6 n6 n7 10000.0
R2r7 data[7] n7 20000.0
Rout n7 vout 1
Rload vout 0 1000000.0
.end
