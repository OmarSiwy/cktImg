.title Summing Amplifier
Vcc vcc 0 15
Vee vee 0 -15
V1 v1 0 1.0
V2 v2 0 0.5
V3 v3 0 -0.3
R1 v1 vminus 10000.0
R2 v2 vminus 10000.0
R3 v3 vminus 10000.0
Rf vminus vout 10000.0
Eamp vout 0 0 vminus 1000000.0
.end
