.title Inverting Amplifier
Vcc vcc 0 15
Vee vee 0 -15
Vin vin 0 0.1
Rin vin vminus 1000.0
Rf vminus vout 10000.0
Rgnd 0 vplus 1000.0
Eamp vout 0 vplus vminus 1000000.0
.end
