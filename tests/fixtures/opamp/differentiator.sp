.title Op-Amp Differentiator
Vcc vcc 0 15
Vee vee 0 -15
Vin vin 0 DC 0 SIN(0 1 1000.0)
Cin vin vminus 1e-08
Rs vin n1 100
Rf vminus vout 10000.0
Cf vminus vout 1e-10
Eamp vout 0 0 vminus 1000000.0
.end
