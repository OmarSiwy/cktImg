.title Non-Inverting Amplifier
Vcc vcc 0 15
Vee vee 0 -15
Vin vin 0 0.1
Rin vin vplus 100
Rg vminus 0 1000.0
Rf vminus vout 10000.0
Eamp vout 0 vplus vminus 1000000.0
.end
