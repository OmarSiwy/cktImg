.title TB Voltage Divider
Xdut vin vout voltage_divider
Vin vin 0 5
Rload vout 0 10000.0
.end
