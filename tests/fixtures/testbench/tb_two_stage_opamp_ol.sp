.title TB Two-Stage Op-Amp Open Loop
Xdut inp inn vout vdd two_stage_opamp
Vdd vdd 0 1.8
Vcm vcm 0 0.9
Vinp inp vcm DC 0 AC 1
Vinn inn vcm 0
Cload vout 0 5e-12
.end
