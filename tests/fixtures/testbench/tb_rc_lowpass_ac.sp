.title TB RC Low-Pass AC
Xdut vin vout rc_lowpass
Vin vin 0 DC 0 AC 1
Rload vout 0 1000000.0
.end
