.title TB Buck Converter Waveforms
Vin vin 0 3.3
Vpwm vpwm 0 PULSE(0 1.8 0 5e-09 5e-09 5.454545454545455e-07 1e-06)
Rhs_on vin sw 0.05
Rls_on sw 0 0.05
L1 sw vout 2.2e-06
Rdcr vout vout_sense 0.02
Cout vout_sense 0 2.2e-05
Rsense vout_sense vload 0.01
Rload vload 0 1.8
.end
