.title TB Bandgap Temperature
Xdut vref vcc bandgap_reference
Vcc vcc 0 3.3
Rprobe vref 0 10000000.0
.end
