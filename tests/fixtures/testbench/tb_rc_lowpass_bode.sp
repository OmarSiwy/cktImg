.title TB RC Bode Plot
Vin vin 0 DC 0 AC 1
R1 vin vout 1000.0
C1 vout 0 1e-07
.end
