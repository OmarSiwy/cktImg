.title TB VCO Kvco
Xdut n1 n2 n3 vctrl vdd vco
Vdd vdd 0 1.8
Vctrl vctrl 0 0.9
Cprobe n1 0 1e-15
.end
