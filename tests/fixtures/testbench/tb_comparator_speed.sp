.title TB Comparator Speed
Xdut vin vref vout vdd comparator
Vdd vdd 0 1.8
Vref vref 0 0.9
Vin vin 0 PULSE(0.89 0.91 0 1e-10 1e-10 2e-08 4e-08)
Cload vout 0 5e-14
.end
