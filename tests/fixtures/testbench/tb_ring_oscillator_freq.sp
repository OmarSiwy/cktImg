.title TB Ring Oscillator Frequency
Xdut n1 n2 n3 vdd ring_oscillator
Vdd vdd 0 1.8
Ckick n1 0 1e-15
.end
