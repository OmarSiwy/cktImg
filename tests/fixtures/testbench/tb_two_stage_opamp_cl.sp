.title TB Two-Stage Op-Amp Closed Loop
Xdut inp inn vout vdd two_stage_opamp
Vdd vdd 0 1.8
Vfb inn vout 0
Vin inp 0 PULSE(0.7 1.1 0 1e-10 1e-10 5e-07 1e-06)
Cload vout 0 5e-12
Rload vout 0 100000.0
.end
