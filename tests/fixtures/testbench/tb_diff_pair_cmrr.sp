.title TB Diff Pair CMRR
Xdut inp inn outp outn vdd diff_pair
Vdd vdd 0 1.8
Vcm vcm 0 0.9
Vdp inp vcm DC 0 AC 0.5
Vdn vcm inn DC 0 AC 0.5
Rprobe_p outp 0 1000000.0
Rprobe_n outn 0 1000000.0
.end
