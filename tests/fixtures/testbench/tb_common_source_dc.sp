.title TB Common Source DC
Xdut vin vout vdd common_source
Vdd vdd 0 1.8
Vin vin 0 0.7
Rprobe vout vout_probe 1
.end
