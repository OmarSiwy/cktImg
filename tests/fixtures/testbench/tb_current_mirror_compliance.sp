.title TB Current Mirror Compliance
Xdut iref iout vdd current_mirror
Vdd vdd 0 1.8
Iref vdd iref 5e-05
Vout iout 0 0.9
.end
