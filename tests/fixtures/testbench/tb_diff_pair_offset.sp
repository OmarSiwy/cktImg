.title TB Diff Pair Offset
Xdut inp inn outp outn vdd diff_pair
Vdd vdd 0 1.8
Vcm vcm 0 0.9
Vdp inp vcm 0
Vdn vcm inn 0
Rp_p outp 0 1000000.0
Rp_n outn 0 1000000.0
.end
