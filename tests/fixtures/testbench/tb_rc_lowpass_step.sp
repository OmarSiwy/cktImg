.title TB RC Low-Pass Step
Xdut vin vout rc_lowpass
Vin vin 0 PULSE(0 1.0 0 1e-09 1e-09 0.01 0.02)
Rload vout 0 1000000.0
.end
