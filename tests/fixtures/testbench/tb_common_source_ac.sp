.title TB Common Source AC
Xdut vin vout vdd common_source
Vdd vdd 0 1.8
Vin vin 0 DC 0.7 AC 1
Cout vout vout_ac 1e-06
Rload vout_ac 0 100000.0
.end
