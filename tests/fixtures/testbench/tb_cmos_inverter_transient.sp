.title TB CMOS Inverter Transient
Xdut vin vout vdd cmos_inverter
Vdd vdd 0 1.8
Vin vin 0 PULSE(0 1.8 0 2e-11 2e-11 5e-10 1e-09)
Cload vout 0 8e-15
.end
