.title TB Telescopic OTA Full
Xdut inp inn outp outn vdd vbn vbp vbpt telescopic_ota
Vdd vdd 0 1.8
Vbn vbn 0 0.6
Vbp vbp 0 1.2
Vbpt vbpt 0 1.0
Vcm vcm 0 0.9
Vdp inp vcm DC 0 AC 0.5
Vdn vcm inn DC 0 AC -0.5
Clp outp 0 2e-12
Cln outn 0 2e-12
.end
