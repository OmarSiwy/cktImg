.title TB CMOS Inverter VTC
Xdut vin vout vdd cmos_inverter
Vdd vdd 0 1.8
Vin vin 0 0.9
Cfan1 vout 0 2e-15
Cfan2 vout 0 2e-15
Cfan3 vout 0 2e-15
Cfan4 vout 0 2e-15
.end
