.title TB LDO PSRR
Xdut vin vout vref ldo_regulator
Vin vin 0 DC 3.3 AC 1
Vref vref 0 1.2
Cout vout 0 4.7e-06
Rload vout 0 36
.end
