.title R-2R DAC 4-bit
Vref vref 0 3.3
Vb3 b3 0 3.3
Vb2 b2 0 0
Vb1 b1 0 3.3
Vb0 b0 0 0
R2r0 b0 n0 20000.0
Rr0 n0 n1 10000.0
R2r1 b1 n1 20000.0
Rr1 n1 n2 10000.0
R2r2 b2 n2 20000.0
Rr2 n2 n3 10000.0
R2r3 b3 n3 20000.0
Rterm n0 0 20000.0
Ebuf vout 0 n3 0 1000000.0
Rfb vout n3 1
.end
