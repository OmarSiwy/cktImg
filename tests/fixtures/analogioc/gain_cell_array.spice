.subckt gain_cell_array_cell wdata wsel rd col vss
Xw wdata wsel store vss sky130_fd_pr__nfet_01v8 W=0.54 L=0.3
Xr col store rd vss sky130_fd_pr__nfet_01v8 W=0.5 L=1.2
Xs store vss sky130_fd_pr__cap_mim_m3_1 W=3.71 L=3.71
.ends gain_cell_array_cell

.subckt gain_cell_array wdata0 wdata1 wdata2 wdata3 wdata4 wdata5 wdata6 wdata7 wsel0 wsel1 wsel2 wsel3 wsel4 wsel5 wsel6 wsel7 rd0 rd1 rd2 rd3 rd4 rd5 rd6 rd7 col0 col1 col2 col3 col4 col5 col6 col7 vss
Xc0_0 wdata0 wsel0 rd0 col0 vss gain_cell_array_cell
Xc0_1 wdata0 wsel1 rd0 col1 vss gain_cell_array_cell
Xc0_2 wdata0 wsel2 rd0 col2 vss gain_cell_array_cell
Xc0_3 wdata0 wsel3 rd0 col3 vss gain_cell_array_cell
Xc0_4 wdata0 wsel4 rd0 col4 vss gain_cell_array_cell
Xc0_5 wdata0 wsel5 rd0 col5 vss gain_cell_array_cell
Xc0_6 wdata0 wsel6 rd0 col6 vss gain_cell_array_cell
Xc0_7 wdata0 wsel7 rd0 col7 vss gain_cell_array_cell
Xc1_0 wdata1 wsel0 rd1 col0 vss gain_cell_array_cell
Xc1_1 wdata1 wsel1 rd1 col1 vss gain_cell_array_cell
Xc1_2 wdata1 wsel2 rd1 col2 vss gain_cell_array_cell
Xc1_3 wdata1 wsel3 rd1 col3 vss gain_cell_array_cell
Xc1_4 wdata1 wsel4 rd1 col4 vss gain_cell_array_cell
Xc1_5 wdata1 wsel5 rd1 col5 vss gain_cell_array_cell
Xc1_6 wdata1 wsel6 rd1 col6 vss gain_cell_array_cell
Xc1_7 wdata1 wsel7 rd1 col7 vss gain_cell_array_cell
Xc2_0 wdata2 wsel0 rd2 col0 vss gain_cell_array_cell
Xc2_1 wdata2 wsel1 rd2 col1 vss gain_cell_array_cell
Xc2_2 wdata2 wsel2 rd2 col2 vss gain_cell_array_cell
Xc2_3 wdata2 wsel3 rd2 col3 vss gain_cell_array_cell
Xc2_4 wdata2 wsel4 rd2 col4 vss gain_cell_array_cell
Xc2_5 wdata2 wsel5 rd2 col5 vss gain_cell_array_cell
Xc2_6 wdata2 wsel6 rd2 col6 vss gain_cell_array_cell
Xc2_7 wdata2 wsel7 rd2 col7 vss gain_cell_array_cell
Xc3_0 wdata3 wsel0 rd3 col0 vss gain_cell_array_cell
Xc3_1 wdata3 wsel1 rd3 col1 vss gain_cell_array_cell
Xc3_2 wdata3 wsel2 rd3 col2 vss gain_cell_array_cell
Xc3_3 wdata3 wsel3 rd3 col3 vss gain_cell_array_cell
Xc3_4 wdata3 wsel4 rd3 col4 vss gain_cell_array_cell
Xc3_5 wdata3 wsel5 rd3 col5 vss gain_cell_array_cell
Xc3_6 wdata3 wsel6 rd3 col6 vss gain_cell_array_cell
Xc3_7 wdata3 wsel7 rd3 col7 vss gain_cell_array_cell
Xc4_0 wdata4 wsel0 rd4 col0 vss gain_cell_array_cell
Xc4_1 wdata4 wsel1 rd4 col1 vss gain_cell_array_cell
Xc4_2 wdata4 wsel2 rd4 col2 vss gain_cell_array_cell
Xc4_3 wdata4 wsel3 rd4 col3 vss gain_cell_array_cell
Xc4_4 wdata4 wsel4 rd4 col4 vss gain_cell_array_cell
Xc4_5 wdata4 wsel5 rd4 col5 vss gain_cell_array_cell
Xc4_6 wdata4 wsel6 rd4 col6 vss gain_cell_array_cell
Xc4_7 wdata4 wsel7 rd4 col7 vss gain_cell_array_cell
Xc5_0 wdata5 wsel0 rd5 col0 vss gain_cell_array_cell
Xc5_1 wdata5 wsel1 rd5 col1 vss gain_cell_array_cell
Xc5_2 wdata5 wsel2 rd5 col2 vss gain_cell_array_cell
Xc5_3 wdata5 wsel3 rd5 col3 vss gain_cell_array_cell
Xc5_4 wdata5 wsel4 rd5 col4 vss gain_cell_array_cell
Xc5_5 wdata5 wsel5 rd5 col5 vss gain_cell_array_cell
Xc5_6 wdata5 wsel6 rd5 col6 vss gain_cell_array_cell
Xc5_7 wdata5 wsel7 rd5 col7 vss gain_cell_array_cell
Xc6_0 wdata6 wsel0 rd6 col0 vss gain_cell_array_cell
Xc6_1 wdata6 wsel1 rd6 col1 vss gain_cell_array_cell
Xc6_2 wdata6 wsel2 rd6 col2 vss gain_cell_array_cell
Xc6_3 wdata6 wsel3 rd6 col3 vss gain_cell_array_cell
Xc6_4 wdata6 wsel4 rd6 col4 vss gain_cell_array_cell
Xc6_5 wdata6 wsel5 rd6 col5 vss gain_cell_array_cell
Xc6_6 wdata6 wsel6 rd6 col6 vss gain_cell_array_cell
Xc6_7 wdata6 wsel7 rd6 col7 vss gain_cell_array_cell
Xc7_0 wdata7 wsel0 rd7 col0 vss gain_cell_array_cell
Xc7_1 wdata7 wsel1 rd7 col1 vss gain_cell_array_cell
Xc7_2 wdata7 wsel2 rd7 col2 vss gain_cell_array_cell
Xc7_3 wdata7 wsel3 rd7 col3 vss gain_cell_array_cell
Xc7_4 wdata7 wsel4 rd7 col4 vss gain_cell_array_cell
Xc7_5 wdata7 wsel5 rd7 col5 vss gain_cell_array_cell
Xc7_6 wdata7 wsel6 rd7 col6 vss gain_cell_array_cell
Xc7_7 wdata7 wsel7 rd7 col7 vss gain_cell_array_cell
.ends gain_cell_array
