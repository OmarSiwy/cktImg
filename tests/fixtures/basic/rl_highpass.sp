.title RL High-Pass Filter
Vin vin 0 1
L1 vin vout 0.01
R1 vout 0 1000.0
.end
