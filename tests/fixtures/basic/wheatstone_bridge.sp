.title Wheatstone Bridge
Vin vin 0 10
R1 vin va 1000.0
R2 va 0 2000.0
R3 vin vb 1000.0
R4 vb 0 2200.0
Rg va vb 10000.0
.end
