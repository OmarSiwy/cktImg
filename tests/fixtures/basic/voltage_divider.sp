.title Voltage Divider
Vin vin 0 5
R1 vin vout 10000.0
R2 vout 0 10000.0
.end
