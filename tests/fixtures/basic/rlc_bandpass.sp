.title RLC Band-Pass Filter
Vin vin 0 1
R1 vin n1 50
L1 n1 n2 0.001
C1 n2 vout 1e-08
Rload vout 0 1000.0
.end
